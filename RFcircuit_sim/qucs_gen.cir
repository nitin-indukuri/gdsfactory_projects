* Qucs 25.2.0  /foss/designs/qucs-download/nmos_op_test.sch
*.INCLUDE "/foss/tools/qucs-s/share/qucs-s/xspice_cmlib/include/ngspice_mathfunc.inc"

*.SUBCKT IHP_PDK_nonlinear_components_sg13_lv_nmos  gnd d g s b w=0.15u l=0.15u ng=1 m=1 mismatch=0 as=0 ad=0 pd=0 ps=0 trise=0 z1=0.34e-6 z2=0.38e-6 wmin=0.15e-6 rfmode=0 pre_layout=1 mlist=1
*X1 d g s b  sg13_lv_nmos w={w} l={l} ng={ng} m={m} mm_ok={mismatch} as={as} ad={ad} pd={pd}
*+ ps={ps} trise={trise} z1={z1} z2={z2} wmin={wmin} rfmode={rfmode} pre_layout={pre_layout}
*.ENDS

.LIB cornerHBT.lib hbt_typ
.LIB cornerRES.lib res_wcs
.LIB cornerCAP.lib cap_typ
.LIB cornerMOSlv.lib mos_tt
VPr1 _net0 _net1 DC 0
VP1 input1 0 dc 0 ac 0.158866 SIN(0 0.158866 3G) portnum 1 z0 50
VP2 output1 0 dc 0 ac 0.632456 SIN(0 0.632456 1MEG) portnum 2 z0 50

XM1 _net1 _net2 0 _net3 sg13_lv_nmos l=0.15u w=0.15u
*M1 _net1 _net2 0 _net3 TYPE1 w=0.15u l=0.15u
V2 _net4 0 DC 1.2
V3 _net5 0 DC 1.5
C3 _net1 output1 1U
C4 input1 _net2 1U
L3 _net0 _net5 1U
L4 _net4 _net2 1U
I1 _net7 _net6 DC 1M

.control

SP LIN 1001 1 1G
let s21_db = db(v(s_2_1))
let s22_db = db(v(s_2_2))
let s12_db = db(v(s_1_2))
let s11_db = db(v(s_1_1))
let s21 = (v(s_2_1))
let s22 = (v(s_2_2))
let s12 = (v(s_1_2))
let s11 = (v(s_1_1))
write spice4qucs.sp1.plot s21_db s22_db s12_db s11_db s21 s22 s12 s11
*destroy all
*reset

*exit
.endc
.END
