* ngspice deck from YAML
* source yaml: /home/nindukuri/GDSFactory/Interview_Projects/gdsfactory_projects/RFcircuit_sim/40G_amp.yaml

.lib /home/nindukuri/IHP-Open-PDK/ihp-sg13g2/libs.tech/ngspice/models/cornerHBT.lib hbt_typ
.lib /home/nindukuri/IHP-Open-PDK/ihp-sg13g2/libs.tech/ngspice/models/cornerRES.lib res_wcs
.lib /home/nindukuri/IHP-Open-PDK/ihp-sg13g2/libs.tech/ngspice/models/cornerCAP.lib cap_typ
.lib /home/nindukuri/IHP-Open-PDK/ihp-sg13g2/libs.tech/ngspice/models/cornerMOSlv.lib mos_tt

* sch_x=0 sch_y=0 sch_r=None
Xq1 n2 n1 0 0 npn13G2 Nx=10 dtemp=0 Ny=1 le=959.9999999999999n we=119.99999999999999n selft=1 sw_nqs=0
* sch_x=-50 sch_y=0 sch_r=None
Xr1 n4 n1 0 rsil dx=8 dy=2
* sch_x=-50 sch_y=-50 sch_r=None
Xc2 n1 n4 cap_cmim w=4u l=4u
* sch_x=-200 sch_y=0 sch_r=None
Xc3 n4 n3 cap_cmim w=2u l=2u
* sch_x=-350 sch_y=0 sch_r=None
Xc4 n3 RF_IN cap_cmim w=3u l=3u
* sch_x=100 sch_y=0 sch_r=None
Xc5 RF_OUT n5 cap_cmim w=5u l=5u
* sch_x=-150 sch_y=-100 sch_r=None
Lil2 VDD_097 n4 395.1p
* sch_x=-300 sch_y=-100 sch_r=None
Lil3 n3 0 293.55p
* sch_x=0 sch_y=100 sch_r=None
Lil4 n2 VDD_165 119.15199999999999p
* sch_x=50 sch_y=0 sch_r=None
Lil5 n2 n5 168.944p

* --- stimulus from YAML port names (RF_* / VDD_*) ---
Vsrc_RF_IN RF_IN 0 dc 0 ac 158.866m SIN(0 158.866m 3g 0 0) portnum 1 z0 50
Vsrc_RF_OUT RF_OUT 0 dc 0 ac 632.456m SIN(0 632.456m 1meg 0 0) portnum 2 z0 50
Vsrc_VDD_097 VDD_097 0 dc 970m
Vsrc_VDD_165 VDD_165 0 dc 1.65

* .control: S-parameter sweep (SP LIN) + amplifier_plots (lets, write, plot)

.control

SP LIN 401 100meg 100g 1
let num = (1/4)*(abs(v(y_2_1)-v(y_1_2))*abs(v(y_2_1)-v(y_1_2)))
let den = real(v(y_1_1))*real(v(y_2_2))-real(v(y_2_1))*real(v(y_1_2))
let Gmax = num/den
let Fmax = sqrt(mag(Gmax))*frequency
let s11_db = db(v(s_1_1))
let s12_db = db(v(s_1_2))
let s21_db = db(v(s_2_1))
let s22_db = db(v(s_2_2))
let s11_mag = mag(v(s_1_1))
let s11_conj = conj(v(s_1_1))
let s12_mag = mag(v(s_1_2))
let s12_conj = conj(v(s_1_2))
let s21_mag = mag(v(s_2_1))
let s21_conj = conj(v(s_2_1))
let s22_mag = mag(v(s_2_2))
let s22_conj = conj(v(s_2_2))
let delta = v(s_1_1)*v(s_2_2)-v(s_1_2)*v(s_2_1)
let delta_mag = mag(delta)
let kf = (1-s11_mag*s11_mag-s22_mag*s22_mag+delta_mag*delta_mag)/(2*mag(v(s_1_2)*v(s_2_1)))
let mu = (1-s11_mag*s11_mag)/(mag(v(s_2_2)-delta*s11_conj)+mag(v(s_1_2)*v(s_2_1)))
let muprime = (1-s22_mag*s22_mag)/(mag(v(s_1_1)-delta*s22_conj)+mag(v(s_1_2)*v(s_2_1)))
write spice4qucs.sp1.plot S_1_1 Y_1_1 Z_1_1 Cy_1_1 S_1_2 Y_1_2 Z_1_2 Cy_1_2 S_2_1 Y_2_1 Z_2_1 Cy_2_1 S_2_2 Y_2_2 Z_2_2 Cy_2_2 Rn NF SOpt NFmin num den Gmax Fmax s11_db s12_db s21_db s22_db s11_mag s11_conj s12_mag s12_conj s21_mag s21_conj s22_mag s22_conj delta delta_mag kf mu muprime
plot s11_db s22_db s21_db ylimit -40 20

.endc
.END
